* Actual LTspice transient; hypothetical linear BVD, not measured.
* Historical command replay is NOT a closed-loop controller implementation.
Vdrive n_src 0 SINE(0 8.7926760992148889 900000)
Va a_cmd 0 1
Vf f_MHz 0 0.9
Rsource n_src n_in 50
Rlesr n_in n_l 6.0352028830488136
Lmatch n_l n_port 0.00010672581904440851 Rser=0
Cmatch n_port n_c 2.8359878734546773e-10
Rcesr n_c 0 0.62355282726312977
Vprobe n_port n_bvd 0
C0 n_bvd 0 6.8580641051984092e-12
Rm n_bvd n_m1 7352.9411764705856
Lm n_m1 n_m2 1.0402283862215378 Rser=0
Cm n_m2 0 3.006260036180247e-14
.options plotwinsize=0 reltol=0.0001 abstol=1p vntol=0.1u
.save V(n_port) I(Vprobe) I(Rm) V(a_cmd) V(f_MHz)
.tran 0 3m 0 1n
.meas tran port_vpp PP V(n_port) FROM 0.0028 TO 0.003
.meas tran port_irms RMS I(Vprobe) FROM 0.0028 TO 0.003
.meas tran motional_power AVG (I(Rm)*I(Rm)*7352.9411764705856) FROM 0.0028 TO 0.003
.end
