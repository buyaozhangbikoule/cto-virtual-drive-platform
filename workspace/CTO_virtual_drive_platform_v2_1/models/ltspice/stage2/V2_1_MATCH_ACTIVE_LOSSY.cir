* V2.1 active lossy L match; same 1 Vrms Thevenin source
* QL=100, QC=1000; ESR values fixed at f0=900000 Hz
Vdrive n_src 0 AC 1
Rsource n_src n_in 50
Rlesr n_in n_l 6.0352028830488136
Lmatch n_l n_port 0.00010672581904440851 Rser=0
Cmatch n_port n_c 2.8359878734546773e-10 Rser=0
Rcesr n_c 0 0.62355282726312977
C0 n_port 0 6.8580641051984092e-12
Rm n_port n_m1 7352.9411764705856
Lm n_m1 n_m2 1.0402283862215378
Cm n_m2 0 3.006260036180247e-14
.save V(n_src) V(n_in) V(n_port) I(Vdrive) I(Rsource) I(Rlesr) I(Lmatch) I(Cmatch) I(Rcesr) I(Rm) I(C0)
.ac lin 20001 800k 1Meg
.options plotwinsize=0
.end
