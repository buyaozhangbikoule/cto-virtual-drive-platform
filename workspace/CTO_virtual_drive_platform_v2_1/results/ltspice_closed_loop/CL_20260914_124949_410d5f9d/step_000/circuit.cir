* OFFLINE CAUSAL FEEDBACK; hypothetical BVD, not hardware.
Vphase cycles 0 PWL(
+ 0 0
+ 0.004 3596
+ )
Va a_cmd 0 PWL(
+ 0 0.4
+ 0.004 0.4
+ )
Vf f_mhz 0 PWL(
+ 0 0.899
+ 0.004 0.899
+ )
Bdrive n_src 0 V=8.7926760992148889*V(a_cmd)*sin(2*pi*V(cycles))
Rsource n_src n_in 50
Rlesr n_in n_l 6.0352028830488136
Lmatch n_l n_port 0.00010672581904440851 Rser=0
Cmatch n_port n_c 2.8359878734546773e-10
Rcesr n_c 0 0.62355282726312977
Vprobe n_port n_bvd 0
C0 n_bvd 0 6.8580641051984092e-12
Rm n_bvd n_m1 7352.9411764705856
Lm n_m1 n_m2 1.0402283862215378 Rser=0
Cm n_m2 0 3.006260036180247e-14
.options plotwinsize=0 reltol=0.0001 abstol=1p vntol=0.1u
.save V(n_port) I(Vprobe) I(Rm) V(a_cmd) V(f_mhz)
.tran 0 0.004 0 2e-09
.meas tran tail_vpp PP V(n_port) FROM 0.0038 TO 0.004
.meas tran tail_irms RMS I(Vprobe) FROM 0.0038 TO 0.004
.meas tran tail_port_power AVG (V(n_port)*I(Vprobe)) FROM 0.0038 TO 0.004
.end
