* Third-step LTspice verification: COMBO::CASE_402_COMBINED_HIGH
* Fresh batch run target: 0.84-0.96 MHz, 0.5 kHz step
* Source amplitude is the calibrated RMS phasor from the assumed BVD model.
V1 src 0 AC 5.3526618424
Rsrc src n_s 60
Rlesr n_s n_l 37.029905484
Lmatch n_l n_in 0.0001309665
Cmatch n_in 0 2.35562e-10
Cstatic n_in 0 1.8e-12
Rmot n_in n_m1 13000
Lmot n_m1 n_m2 0.1
Cmot n_m2 0 3.32362315442e-13
.ac lin 241 840000 960000
.options meascplxfmt=cartesian
.meas ac Zin_mag_0p9 FIND mag(V(n_s)/I(Rlesr)) AT=900000
.meas ac Zin_real_0p9 FIND re(V(n_s)/I(Rlesr)) AT=900000
.meas ac Zin_imag_0p9 FIND im(V(n_s)/I(Rlesr)) AT=900000
.meas ac Phase_0p9 FIND ph(V(n_s)/I(Rlesr)) AT=900000
.meas ac P_0p9 FIND re(V(n_in)*conj(I(Rmot))) AT=900000
.meas ac Gamma_0p9 FIND mag((V(n_s)/I(Rlesr)-60)/(V(n_s)/I(Rlesr)+60)) AT=900000
.meas ac Pmax MAX re(V(n_in)*conj(I(Rmot)))
.end
