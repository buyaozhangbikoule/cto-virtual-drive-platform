* V2.1 before matching; AC 1 interpreted as 1 Vrms equivalent
Vdrive n_src 0 AC 1
Rsource n_src n_port 50
C0 n_port 0 6.8580641051984092e-12
Rm n_port n_m1 7352.9411764705856
Lm n_m1 n_m2 1.0402283862215378
Cm n_m2 0 3.006260036180247e-14
.save V(n_src) V(n_port) I(Vdrive) I(Rsource) I(Rm) I(C0)
.ac lin 20001 800k 1Meg
.options plotwinsize=0
.end
