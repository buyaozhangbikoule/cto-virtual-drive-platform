* CASE_000_BASELINE: assumed single-factor BVD disturbance case
* All unlisted parameters remain at baseline.
* AC amplitudes are RMS phasors. Current limits use BVD total terminal peak current.
V1 src 0 AC 5.3526618424
Rsrc src n_s 50
Rlesr n_s n_l 7.05331533028
Lmatch n_l n_in 0.00012473
Cmatch n_in 0 2.4796e-10
Cstatic n_in 0 1.5e-12
Rmot n_in n_m1 10000
Lmot n_m1 n_m2 0.1
Cmot n_m2 0 3.1272e-13
.ac lin 4001 800000 1000000
.options meascplxfmt=cartesian
.meas ac Zin_mag_fixed FIND mag(V(n_s)/I(Rlesr)) AT=900000
.meas ac Zin_real_fixed FIND re(V(n_s)/I(Rlesr)) AT=900000
.meas ac Zin_imag_fixed FIND im(V(n_s)/I(Rlesr)) AT=900000
.meas ac Phase_fixed FIND ph(V(n_s)/I(Rlesr)) AT=900000
.meas ac Vpp_fixed FIND mag(V(n_in))*2*sqrt(2) AT=900000
.meas ac Itrans_peak_fixed FIND mag(I(Rmot)+I(Cstatic))*sqrt(2) AT=900000
.meas ac Imot_peak_fixed FIND mag(I(Rmot))*sqrt(2) AT=900000
.meas ac Isource_peak_fixed FIND mag(I(Rlesr))*sqrt(2) AT=900000
.meas ac P_fixed FIND re(V(n_in)*conj(I(Rmot))) AT=900000
.meas ac Gamma_fixed FIND mag((V(n_s)/I(Rlesr)-50)/(V(n_s)/I(Rlesr)+50)) AT=900000
.meas ac Pmax MAX re(V(n_in)*conj(I(Rmot)))
.end
