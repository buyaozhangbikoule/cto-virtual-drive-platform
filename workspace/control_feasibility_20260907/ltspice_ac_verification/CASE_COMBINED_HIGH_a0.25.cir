* CASE_COMBINED_HIGH; assumed BVD; independent AC verification; a=0.25
Vdrive n_src 0 AC 1.554340223632932
Rsource n_src n_in 60
Rlesr n_in n_l 33.193615856768474
Lmatch n_l n_port 0.00011739840094884937
Cmatch n_port n_c 2.5523890861092097e-10
Rcesr n_c 0 0.69283647473681076
C0 n_port 0 8.9154833367579324e-12
Rm n_port n_m1 11029.411764705877
Lm n_m1 n_m2 1.6424658729813753
Cm n_m2 0 2.1096561657405244e-14
.ac lin 2001 800000 1000000
.options plotwinsize=0
.save V(n_src) V(n_in) V(n_port) I(Rsource) I(Rm) I(C0) I(Rlesr) I(Rcesr)
.end
