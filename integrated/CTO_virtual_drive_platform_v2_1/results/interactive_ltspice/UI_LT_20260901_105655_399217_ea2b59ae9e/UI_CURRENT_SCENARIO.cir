* UI_LTSPICE_CURRENT_SCENARIO; MODEL_V2_1_HYPOTHETICAL; AC RMS-equivalent source
* Generated from Streamlit controls; not a measured transducer or switching-amplifier model.
Vdrive n_src 0 AC 4.9738887156253826
Rsource n_src n_in 55.000000000000007
Rlesr n_in n_l 13.277446342707389
Lmatch n_l n_port 0.00011739840094884937
Cmatch n_port n_c 2.8359878734546773e-10
Rcesr n_c 0 0.62355282726312977
C0 n_port 0 7.5438705157182513e-12
Rm n_port n_m1 8455.8823529411729
Lm n_m1 n_m2 1.0402283862215378
Cm n_m2 0 3.006260036180247e-14
.ac lin 201 800000 1000000
.options plotwinsize=0
.save V(n_src) V(n_in) V(n_port) I(Rsource) I(Rm) I(C0) I(Rlesr) I(Rcesr)
.end
